Belasteter Resistent codensator
V1 in 0 PULSE(0 5 1m 1u 1u 10m 20m)
R1 in out 1k
C1 out 0 1u
RL out 0 1k

.control
set wr_singlescale
set wr_vecnames
op
print v(in) v(out) i(V1)
tran  10u 25ms
wrdata results/belasteter_tran.txt v(in) v(out) i(V1)
quit
.endc
.end
