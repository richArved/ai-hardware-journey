Voltage divider: 5 V, two 1 kohm resistors
V1 in 0 DC 5
R1 in out 2k
R2 out 0 1k
.op
.dc V1 0 5 0.1
.control
set wr_singlescale
set wr_vecnames
op
print v(in) v(out) i(V1)
dc V1 0 5 0.1
wrdata results/divider_dc.txt v(in) v(out)
quit
.endc
.end
