RC low-pass: 1 kohm and 1 uF, tau = 1 ms
V1 in 0 PULSE(0 5 1m 1u 1u 20m 40m)
R1 in out 1k
C1 out 0 1u
.tran 10u 7m 0 10u
.control
set wr_singlescale
set wr_vecnames
run
wrdata results/rc_tran.txt v(in) v(out)
quit
.endc
.end
